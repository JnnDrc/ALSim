* Generated by Al.Sim!
V1 1 0 12.0
R1 0 1 1000.0
R2 0 2 1000.0
R3 2 3 1000.0
R4 3 4 1000.0
R5 4 5 1000.0
R6 5 6 1000.0
R7 6 7 1000.0
R8 7 1 1000.0
R9 1 8 1000.0
R10 8 5 1000.0
R11 8 7 1000.0
R12 8 6 1000.0
R13 8 0 1000.0
R14 8 2 1000.0
R15 8 3 1000.0
R16 8 4 1000.0
.end
